ADE simulation setup
Test lab1_AND_1: lab1/AND/schematic, simulator spectre
  Models: /util-cse/cadence/local/gpdk045_v_6_0/gpdk045/../models/spectre/gpdk045.scs[mc]
  Temperature: 27
  Stimulus A: voltage pulse val0=0 val1=1 period=2n width=1n srcType=pulse
  Stimulus B: voltage pulse val0=0 val1=1 period=4n width=2n srcType=pulse
  Stimulus vdd!: voltage dc dc=1 srcType=dc
  Analysis tran: stop=32n
  Signals: /A, /B, /Out
Run mode: Single Run, Sweeps and Corners
