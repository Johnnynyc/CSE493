ADE simulation setup
Run mode: Single Run, Sweeps and Corners
Tests:
  lab1_AND_1: lab1/AND/schematic, simulator spectre
    Outputs: /A; /B; "/out"; "/Out"; /Out
