ADE simulation setup
Run mode: Single Run, Sweeps and Corners
Tests:
  KoggeStone_ALU_and_4bit_1: KoggeStone_ALU/and_4bit/schematic, simulator spectre
    Outputs: /A; /B; /C; /D; /Out
