ADE simulation setup
Run mode: Single Run, Sweeps and Corners
Tests:
  Lab1_xor_1: Lab1/xor/schematic, simulator spectre
    Outputs: /A; /B; /out
