ADE simulation setup
Test Lab1_nand_1: Lab1/nand/schematic, simulator spectre
  Models: /util-cse/cadence/local/gpdk045_v_6_0/gpdk045/../models/spectre/gpdk045.scs[mc]
  Temperature: 27
  Stimulus in_a: voltage pulse val0=0 val1=1 period=8n width=4n srcType=pulse
  Stimulus in_b: voltage pulse val0=0 val1=1 period=4n width=2n srcType=pulse
  Stimulus vdd!: voltage dc dc=1 srcType=dc
  Analysis tran: stop=16n
  Signals: /in_a, /in_b, /out
