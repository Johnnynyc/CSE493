ADE simulation setup
Run mode: Single Run, Sweeps and Corners
Tests:
  project_Step-Pre_1: project/Step-Pre/schematic, simulator spectre
    Outputs: /A0; /A1; /A2; /A3; "/B1"; /B1; /B2; /B3; /Cin; /P00; /P01; "/P02"; /P02; /P03; /B0; /G00; /G01; /G02; /G03
