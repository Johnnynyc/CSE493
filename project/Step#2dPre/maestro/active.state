ADE simulation setup
Test project_Step-Pre_1: project/Step-Pre/schematic, simulator spectre
  Models: /util-cse/cadence/local/gpdk045_v_6_0/gpdk045/../models/spectre/gpdk045.scs[mc]
  Temperature: 27
  Stimulus vdd!: voltage dc dc=1 srcType=dc
  Stimulus A0: voltage pulse val0=0 val1=1 period=50n width=25n srcType=pulse
  Stimulus B0: voltage pulse val0=0 val1=0 period=50n width=25n srcType=pulse
  Stimulus Cin: voltage pulse val0=0 val1=1 period=50n width=25n srcType=pulse
  Stimulus A1: voltage pulse val0=0 val1=0 period=50n width=25n srcType=pulse
  Stimulus B1: voltage pulse val0=0 val1=0 period=50n width=25n srcType=pulse
  Stimulus A2: voltage pulse val0=0 val1=0 period=50n width=25n srcType=pulse
  Stimulus B2: voltage pulse val0=0 val1=1 period=50n width=25n srcType=pulse
  Stimulus A3: voltage pulse val0=0 val1=1 period=50n width=25n srcType=pulse
  Stimulus B3: voltage pulse val0=0 val1=1 period=50n width=25n srcType=pulse
  Analysis tran: stop=20n
  Signals: /A0, /A1, /A2, /A3, /B0, /B1, /B2, /B3, /Cin, /P00, /P01, /P02, /P03, /G00, /G01, /G02, /G03
Run mode: Single Run, Sweeps and Corners
