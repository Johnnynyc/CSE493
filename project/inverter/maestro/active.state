ADE simulation setup
Test Lab1_inverter_1: Lab1/inverter/schematic, simulator spectre
  Models: /util-cse/cadence/local/gpdk045_v_6_0/gpdk045/../models/spectre/gpdk045.scs[mc]
  Temperature: 27
  Stimulus vdd!: voltage dc dc=1 srcType=dc
  Stimulus in: voltage pulse val0=0 val1=1 period=2n width=1n srcType=pulse
  Analysis tran: stop=4n
  Signals: /in, /out
Run mode: Single Run, Sweeps and Corners
