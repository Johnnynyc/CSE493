ADE simulation setup
Run mode: Single Run, Sweeps and Corners
Tests:
  Lab1_inverter_1: Lab1/inverter/schematic, simulator spectre
    Outputs: /in; /out
