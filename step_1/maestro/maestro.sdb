ADE simulation setup
Run mode: Single Run, Sweeps and Corners
Tests:
  CSE493_step_1_1: CSE493/step_1/schematic, simulator spectre
    Outputs: /G00; /G01; /G02; /G03; /P01; /P02; /P03; /G10; /G11; /P12; /G12; /P13; /G13
