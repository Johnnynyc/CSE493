ADE simulation setup
Test CSE493_step_1_1: CSE493/step_1/schematic, simulator spectre
  Models: /util-cse/cadence/local/gpdk045_v_6_0/gpdk045/../models/spectre/gpdk045.scs[mc]
  Temperature: 27
  Stimulus G00: voltage pulse val0=0 val1=1 period=4n width=1n srcType=pulse
  Stimulus G01: voltage pulse val0=0 val1=1 period=2n width=1n srcType=pulse
  Stimulus G03: voltage pulse val0=0 val1=1 period=4n width=1n srcType=pulse
  Stimulus P01: voltage pulse val0=0 val1=1 period=2n width=1n srcType=pulse
  Stimulus P02: voltage pulse val0=0 val1=1 period=4n width=1n srcType=pulse
  Stimulus P03: voltage pulse val0=0 val1=1 period=2n width=1n srcType=pulse
  Stimulus G02: voltage pulse val0=0 val1=1 period=4n width=1n srcType=pulse
  Stimulus vdd!: voltage dc dc=1 srcType=dc
  Analysis tran: stop=16n
  Signals: /G00, /G01, /G02, /G03, /P01, /P02, /P03, /G10, /G11, /P12, /G12, /P13, /G13
Run mode: Single Run, Sweeps and Corners
