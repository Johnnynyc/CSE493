ADE simulation setup
Run mode: Single Run, Sweeps and Corners
Tests:
  CSE493_4b_SLL__1: CSE493/4b_SLL_/schematic, simulator spectre
    Outputs: /Bit3; /Bit0; /Bit1; /Bit2; /SHIFT; /Y3; /Y1; /Y0; /Y2
