ADE simulation setup
Run mode: Single Run, Sweeps and Corners
Tests:
  project_4b_SLL_1: project/4b_SLL/schematic, simulator spectre
    Outputs: /SHIFT; /Bit0; /Bit1; /Bit2; /Bit3; /Y0; /Y1; /Y2; /Y3
