ADE simulation setup
Test project_4b_SLL_1: project/4b_SLL/schematic, simulator spectre
  Models: /util-cse/cadence/local/gpdk045_v_6_0/gpdk045/../models/spectre/gpdk045.scs[mc]
  Temperature: 27
  Stimulus Bit0: voltage pulse dc=1 val0=0 val1=1 period=2n width=1n srcType=pulse
  Stimulus Bit1: voltage pulse dc=1 val0=0 val1=1 period=4n width=1n srcType=pulse
  Stimulus Bit2: voltage pulse dc=1 val0=0 val1=1 period=2n width=1n srcType=pulse
  Stimulus Bit3: voltage pulse dc=1 val0=0 val1=1 period=4n width=1n srcType=pulse
  Stimulus SHIFT: voltage pulse dc=1 val0=0 val1=1 period=8n width=1n srcType=pulse
  Analysis tran: stop=16n
  Signals: /SHIFT, /Bit0, /Bit1, /Bit2, /Bit3, /Y0, /Y1, /Y2, /Y3
Run mode: Single Run, Sweeps and Corners
