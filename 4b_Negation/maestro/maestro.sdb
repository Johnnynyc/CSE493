ADE simulation setup
Run mode: Single Run, Sweeps and Corners
Tests:
  project_Negation_1: project/4b_Negation/schematic, simulator spectre
    Outputs: /A; /B; /C; /D; /Aout; /Bout; /Cout; /Dout
