ADE simulation setup
Test KoggeStone_ALU_nand_4bit_1: KoggeStone_ALU/nand_4bit/schematic, simulator spectre
  Models: /util-cse/cadence/local/gpdk045_v_6_0/gpdk045/../models/spectre/gpdk045.scs[mc]
  Temperature: 27
  Stimulus vdd!: voltage dc dc=1 srcType=dc
  Stimulus A: voltage pulse val0=0 val1=1 period=16n rise=10p fall=10p width=8n srcType=pulse
  Stimulus B: voltage pulse val0=0 val1=1 period=8n rise=10p fall=10p width=4n srcType=pulse
  Stimulus C: voltage pulse val0=0 val1=1 period=4n rise=10p fall=10p width=2n srcType=pulse
  Stimulus D: voltage pulse val0=0 val1=1 period=2n rise=10p fall=10p width=1n srcType=pulse
  Analysis tran: stop=32n
  Signals: /A, /B, /C, /D, /Out
Run mode: Single Run, Sweeps and Corners
