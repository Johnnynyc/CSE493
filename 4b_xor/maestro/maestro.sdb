ADE simulation setup
Run mode: Single Run, Sweeps and Corners
Tests:
  project_4b_xor_1: project/4b_xor/schematic, simulator spectre
    Outputs: a0; b0; o0; a1; b1; o1; a2; b2; o2; a3; b3; o3
