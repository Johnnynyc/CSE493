ADE simulation setup
Test project_4b_xor_1: project/4b_xor/schematic, simulator spectre
  Models: /util-cse/cadence/local/gpdk045_v_6_0/gpdk045/../models/spectre/gpdk045.scs[mc]
  Temperature: 27
  Stimulus vdd!: voltage dc dc=1 srcType=dc
  Stimulus A0: voltage pulse val0=0 val1=1 period=2n width=1n srcType=pulse
  Stimulus A2: voltage pulse val0=0 val1=1 period=2n width=1n srcType=pulse
  Stimulus B2: voltage pulse val0=0 val1=1 period=4n width=2n srcType=pulse
  Stimulus B0: voltage pulse val0=0 val1=1 period=4n width=2n srcType=pulse
  Stimulus A3: voltage pulse val0=0 val1=1 period=2n width=1n srcType=pulse
  Stimulus B3: voltage pulse val0=0 val1=1 period=4n width=2n srcType=pulse
  Stimulus A1: voltage pulse val0=0 val1=1 period=2n width=1n srcType=pulse
  Stimulus B1: voltage pulse val0=0 val1=1 period=4n width=2n srcType=pulse
  Analysis tran: stop=4n
  Signals: /A0 as a0, /B0 as b0, /o0 as o0, /A1 as a1, /B1 as b1, /o1 as o1, /A2 as a2, /B2 as b2, /o2 as o2, /A3 as a3, /B3 as b3, /o3 as o3
Run mode: Single Run, Sweeps and Corners
