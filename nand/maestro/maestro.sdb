ADE simulation setup
Run mode: Single Run, Sweeps and Corners
Tests:
  Lab1_nand_1: Lab1/nand/schematic, simulator spectre
    Outputs: /in_a; /in_b; /out
