ADE simulation setup
Run mode: Single Run, Sweeps and Corners
Tests:
  Lab1_nor_1: Lab1/nor/schematic, simulator spectre
    Outputs: /in_a; /in_b; /out
