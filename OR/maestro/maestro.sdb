ADE simulation setup
Run mode: Single Run, Sweeps and Corners
Tests:
  lab1_OR_1: lab1/OR/schematic, simulator spectre
    Outputs: /A; /B; "/Vout"; "/out"; /out
