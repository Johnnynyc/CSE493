ADE simulation setup
Run mode: Single Run, Sweeps and Corners
Tests:
  CSE493_4b_SLR_1: CSE493/4b_SLR/schematic, simulator spectre
    Outputs: /Bit0; /Bit1; /Bit2; /Bit3; /SHIFT; /Y0; /Y1; /Y2; /Y3
