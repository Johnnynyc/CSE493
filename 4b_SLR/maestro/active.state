ADE simulation setup
Test CSE493_4b_SLR_1: CSE493/4b_SLR/schematic, simulator spectre
  Models: /util-cse/cadence/local/gpdk045_v_6_0/gpdk045/../models/spectre/gpdk045.scs[mc]
  Temperature: 27
  Stimulus SHIFT: voltage pulse dc=1 val0=0 val1=1 period=8n width=4n srcType=pulse
  Stimulus Bit3: voltage pulse dc=1 val0=0 val1=1 period=4n width=2n srcType=pulse
  Stimulus Bit2: voltage pulse dc=1 val0=0 val1=1 period=2n width=1n srcType=pulse
  Stimulus Bit1: voltage pulse dc=1 val0=0 val1=1 period=4n width=2n srcType=pulse
  Stimulus Bit0: voltage pulse dc=1 val0=0 val1=1 period=2n width=1n srcType=pulse
  Stimulus vdd!: voltage dc dc=1 srcType=dc
  Analysis tran: stop=16n
  Signals: /Bit0, /Bit1, /Bit2, /Bit3, /SHIFT, /Y0, /Y1, /Y2, /Y3
Run mode: Single Run, Sweeps and Corners
