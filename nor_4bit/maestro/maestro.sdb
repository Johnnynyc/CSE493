ADE simulation setup
Run mode: Single Run, Sweeps and Corners
Tests:
  KoggeStone_ALU2_nor_4bit_1: KoggeStone_ALU/nor_4bit/schematic, simulator spectre
    Outputs: /A; /B; /C; /D; /Out
