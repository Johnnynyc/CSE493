ADE simulation setup
Test project_4b_inverter_1: project/4b_inverter/schematic, simulator spectre
  Models: /util-cse/cadence/local/gpdk045_v_6_0/gpdk045/../models/spectre/gpdk045.scs[mc]
  Temperature: 27
  Stimulus i0: voltage pulse val0=0 val1=1 period=2n width=1n srcType=pulse
  Stimulus i1: voltage pulse val0=0 val1=1 period=4n width=2n srcType=pulse
  Stimulus i2: voltage pulse val0=0 val1=1 period=8n width=4n srcType=pulse
  Stimulus i3: voltage pulse val0=0 val1=1 period=16n width=8n srcType=pulse
  Analysis tran: stop=16n
  Signals: /i0 as i0, /i1 as i1, /i2 as i2, /i3 as i3, /o0 as o0, /o1 as o1, /o2 as o2, /o3 as o3
Run mode: Single Run, Sweeps and Corners
