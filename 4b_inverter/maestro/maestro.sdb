ADE simulation setup
Run mode: Single Run, Sweeps and Corners
Tests:
  project_4b_inverter_1: project/4b_inverter/schematic, simulator spectre
    Outputs: i0; i1; i2; i3; o0; o1; o2; o3
