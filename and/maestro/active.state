ADE simulation setup
Test CSE493_and_1: CSE493/and/schematic, simulator spectre
  Models: /util-cse/cadence/local/gpdk045_v_6_0/gpdk045/../models/spectre/gpdk045.scs[mc]
  Temperature: 27
  Stimulus A: voltage pulse dc=0 val0=1 val1=0 period=2n width=2n srcType=pulse
  Stimulus B: voltage pulse dc=0 val0=0 val1=1 period=2n width=1n srcType=pulse
  Stimulus vdd!: voltage dc dc=1 srcType=dc
  Analysis tran: stop=16n
  Signals: /A, /B, /Out
