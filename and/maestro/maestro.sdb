ADE simulation setup
Run mode: Single Run, Sweeps and Corners
Tests:
  Project_AND_1: Project/and/schematic, simulator spectre
    Outputs: /A; /B; /Out
