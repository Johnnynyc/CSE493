ADE simulation setup
Run mode: Single Run, Sweeps and Corners
Tests:
  CSE493_and_1: CSE493/and/schematic, simulator spectre
    Outputs: /A; /B; /Out
